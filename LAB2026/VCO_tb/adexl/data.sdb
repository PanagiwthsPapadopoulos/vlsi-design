ADE simulation setup
Run mode: Single Run, Sweeps and Corners
Tests:
  labs_2025:VCO_tb:1: LAB2026/VCO_tb/schematic, simulator spectre
Global variables:
  vbias = 0.8
  Vc = 0.3
  vdd = 1
Corners:
  model folders: /mnt/apps/prebuilt/EDA/designkits/GPDK/gpdk045_v_6_0/gpdk045/../models/spectre
  C0 (off): Vc=0:0.2:3.3; gpdk045.scs[tt]
