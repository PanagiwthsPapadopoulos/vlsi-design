ADE simulation setup
Run mode: Single Run, Sweeps and Corners
Tests:
  labs_2025:CM_tb:1: LAB2026/CM_tb/config, simulator spectre
    Outputs: /NM0/D; /NM1/D; /NM2/D; /net1; /VGS1; /VGS2
Corners (nominal off):
  model folders: /mnt/apps/prebuilt/EDA/designkits/GPDK/gpdk045_v_6_0/gpdk045/../models/spectre
  C0: gpdk045.scs[tt]
